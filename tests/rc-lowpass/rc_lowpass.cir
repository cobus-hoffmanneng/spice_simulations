* First-order RC low-pass filter - AC analysis (netlist fallback, mirrors rc_lowpass.asc)
* Target corner: fc = 1/(2*pi*R*C) = 1/(2*pi*1.5915k*100n) = 1.000 kHz
V1 in 0 AC 1
R1 in out 1.5915k
C1 out 0 100n
.ac dec 100 1 1Meg
.meas AC Fc WHEN mag(V(out))=0.70710678
.backanno
.end
